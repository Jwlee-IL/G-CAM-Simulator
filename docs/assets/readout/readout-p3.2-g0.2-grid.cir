* Anger-Grid on p3.2-g0.2: CornerGrid, 12 x 12 SiPM nodes
* Gcam TODO-19 charge-division network (RD-10), generated from the engine's readout configuration.
* Illustrative generic network, not a buildable design. I_S<k> = SiPM k (k = ky*Sx + kx), 0 A each;
* a nodal solver drives one source at a time with 1 A. V_<c> = 0 V ammeter (virtual-ground input) or
* R_LOAD_<c> = amplifier input impedance; outputs A..D = x-y-, x+y-, x-y+, x+y+.
I_S0 0 S0_0 DC 0
I_S1 0 S1_0 DC 0
I_S2 0 S2_0 DC 0
I_S3 0 S3_0 DC 0
I_S4 0 S4_0 DC 0
I_S5 0 S5_0 DC 0
I_S6 0 S6_0 DC 0
I_S7 0 S7_0 DC 0
I_S8 0 S8_0 DC 0
I_S9 0 S9_0 DC 0
I_S10 0 S10_0 DC 0
I_S11 0 S11_0 DC 0
I_S12 0 S0_1 DC 0
I_S13 0 S1_1 DC 0
I_S14 0 S2_1 DC 0
I_S15 0 S3_1 DC 0
I_S16 0 S4_1 DC 0
I_S17 0 S5_1 DC 0
I_S18 0 S6_1 DC 0
I_S19 0 S7_1 DC 0
I_S20 0 S8_1 DC 0
I_S21 0 S9_1 DC 0
I_S22 0 S10_1 DC 0
I_S23 0 S11_1 DC 0
I_S24 0 S0_2 DC 0
I_S25 0 S1_2 DC 0
I_S26 0 S2_2 DC 0
I_S27 0 S3_2 DC 0
I_S28 0 S4_2 DC 0
I_S29 0 S5_2 DC 0
I_S30 0 S6_2 DC 0
I_S31 0 S7_2 DC 0
I_S32 0 S8_2 DC 0
I_S33 0 S9_2 DC 0
I_S34 0 S10_2 DC 0
I_S35 0 S11_2 DC 0
I_S36 0 S0_3 DC 0
I_S37 0 S1_3 DC 0
I_S38 0 S2_3 DC 0
I_S39 0 S3_3 DC 0
I_S40 0 S4_3 DC 0
I_S41 0 S5_3 DC 0
I_S42 0 S6_3 DC 0
I_S43 0 S7_3 DC 0
I_S44 0 S8_3 DC 0
I_S45 0 S9_3 DC 0
I_S46 0 S10_3 DC 0
I_S47 0 S11_3 DC 0
I_S48 0 S0_4 DC 0
I_S49 0 S1_4 DC 0
I_S50 0 S2_4 DC 0
I_S51 0 S3_4 DC 0
I_S52 0 S4_4 DC 0
I_S53 0 S5_4 DC 0
I_S54 0 S6_4 DC 0
I_S55 0 S7_4 DC 0
I_S56 0 S8_4 DC 0
I_S57 0 S9_4 DC 0
I_S58 0 S10_4 DC 0
I_S59 0 S11_4 DC 0
I_S60 0 S0_5 DC 0
I_S61 0 S1_5 DC 0
I_S62 0 S2_5 DC 0
I_S63 0 S3_5 DC 0
I_S64 0 S4_5 DC 0
I_S65 0 S5_5 DC 0
I_S66 0 S6_5 DC 0
I_S67 0 S7_5 DC 0
I_S68 0 S8_5 DC 0
I_S69 0 S9_5 DC 0
I_S70 0 S10_5 DC 0
I_S71 0 S11_5 DC 0
I_S72 0 S0_6 DC 0
I_S73 0 S1_6 DC 0
I_S74 0 S2_6 DC 0
I_S75 0 S3_6 DC 0
I_S76 0 S4_6 DC 0
I_S77 0 S5_6 DC 0
I_S78 0 S6_6 DC 0
I_S79 0 S7_6 DC 0
I_S80 0 S8_6 DC 0
I_S81 0 S9_6 DC 0
I_S82 0 S10_6 DC 0
I_S83 0 S11_6 DC 0
I_S84 0 S0_7 DC 0
I_S85 0 S1_7 DC 0
I_S86 0 S2_7 DC 0
I_S87 0 S3_7 DC 0
I_S88 0 S4_7 DC 0
I_S89 0 S5_7 DC 0
I_S90 0 S6_7 DC 0
I_S91 0 S7_7 DC 0
I_S92 0 S8_7 DC 0
I_S93 0 S9_7 DC 0
I_S94 0 S10_7 DC 0
I_S95 0 S11_7 DC 0
I_S96 0 S0_8 DC 0
I_S97 0 S1_8 DC 0
I_S98 0 S2_8 DC 0
I_S99 0 S3_8 DC 0
I_S100 0 S4_8 DC 0
I_S101 0 S5_8 DC 0
I_S102 0 S6_8 DC 0
I_S103 0 S7_8 DC 0
I_S104 0 S8_8 DC 0
I_S105 0 S9_8 DC 0
I_S106 0 S10_8 DC 0
I_S107 0 S11_8 DC 0
I_S108 0 S0_9 DC 0
I_S109 0 S1_9 DC 0
I_S110 0 S2_9 DC 0
I_S111 0 S3_9 DC 0
I_S112 0 S4_9 DC 0
I_S113 0 S5_9 DC 0
I_S114 0 S6_9 DC 0
I_S115 0 S7_9 DC 0
I_S116 0 S8_9 DC 0
I_S117 0 S9_9 DC 0
I_S118 0 S10_9 DC 0
I_S119 0 S11_9 DC 0
I_S120 0 S0_10 DC 0
I_S121 0 S1_10 DC 0
I_S122 0 S2_10 DC 0
I_S123 0 S3_10 DC 0
I_S124 0 S4_10 DC 0
I_S125 0 S5_10 DC 0
I_S126 0 S6_10 DC 0
I_S127 0 S7_10 DC 0
I_S128 0 S8_10 DC 0
I_S129 0 S9_10 DC 0
I_S130 0 S10_10 DC 0
I_S131 0 S11_10 DC 0
I_S132 0 S0_11 DC 0
I_S133 0 S1_11 DC 0
I_S134 0 S2_11 DC 0
I_S135 0 S3_11 DC 0
I_S136 0 S4_11 DC 0
I_S137 0 S5_11 DC 0
I_S138 0 S6_11 DC 0
I_S139 0 S7_11 DC 0
I_S140 0 S8_11 DC 0
I_S141 0 S9_11 DC 0
I_S142 0 S10_11 DC 0
I_S143 0 S11_11 DC 0
R1 S0_0 S1_0 1000
R2 S0_0 S0_1 1000
R3 S1_0 S2_0 1000
R4 S1_0 S1_1 1000
R5 S2_0 S3_0 1000
R6 S2_0 S2_1 1000
R7 S3_0 S4_0 1000
R8 S3_0 S3_1 1000
R9 S4_0 S5_0 1000
R10 S4_0 S4_1 1000
R11 S5_0 S6_0 1000
R12 S5_0 S5_1 1000
R13 S6_0 S7_0 1000
R14 S6_0 S6_1 1000
R15 S7_0 S8_0 1000
R16 S7_0 S7_1 1000
R17 S8_0 S9_0 1000
R18 S8_0 S8_1 1000
R19 S9_0 S10_0 1000
R20 S9_0 S9_1 1000
R21 S10_0 S11_0 1000
R22 S10_0 S10_1 1000
R23 S11_0 S11_1 1000
R24 S0_1 S1_1 1000
R25 S0_1 S0_2 1000
R26 S1_1 S2_1 1000
R27 S1_1 S1_2 1000
R28 S2_1 S3_1 1000
R29 S2_1 S2_2 1000
R30 S3_1 S4_1 1000
R31 S3_1 S3_2 1000
R32 S4_1 S5_1 1000
R33 S4_1 S4_2 1000
R34 S5_1 S6_1 1000
R35 S5_1 S5_2 1000
R36 S6_1 S7_1 1000
R37 S6_1 S6_2 1000
R38 S7_1 S8_1 1000
R39 S7_1 S7_2 1000
R40 S8_1 S9_1 1000
R41 S8_1 S8_2 1000
R42 S9_1 S10_1 1000
R43 S9_1 S9_2 1000
R44 S10_1 S11_1 1000
R45 S10_1 S10_2 1000
R46 S11_1 S11_2 1000
R47 S0_2 S1_2 1000
R48 S0_2 S0_3 1000
R49 S1_2 S2_2 1000
R50 S1_2 S1_3 1000
R51 S2_2 S3_2 1000
R52 S2_2 S2_3 1000
R53 S3_2 S4_2 1000
R54 S3_2 S3_3 1000
R55 S4_2 S5_2 1000
R56 S4_2 S4_3 1000
R57 S5_2 S6_2 1000
R58 S5_2 S5_3 1000
R59 S6_2 S7_2 1000
R60 S6_2 S6_3 1000
R61 S7_2 S8_2 1000
R62 S7_2 S7_3 1000
R63 S8_2 S9_2 1000
R64 S8_2 S8_3 1000
R65 S9_2 S10_2 1000
R66 S9_2 S9_3 1000
R67 S10_2 S11_2 1000
R68 S10_2 S10_3 1000
R69 S11_2 S11_3 1000
R70 S0_3 S1_3 1000
R71 S0_3 S0_4 1000
R72 S1_3 S2_3 1000
R73 S1_3 S1_4 1000
R74 S2_3 S3_3 1000
R75 S2_3 S2_4 1000
R76 S3_3 S4_3 1000
R77 S3_3 S3_4 1000
R78 S4_3 S5_3 1000
R79 S4_3 S4_4 1000
R80 S5_3 S6_3 1000
R81 S5_3 S5_4 1000
R82 S6_3 S7_3 1000
R83 S6_3 S6_4 1000
R84 S7_3 S8_3 1000
R85 S7_3 S7_4 1000
R86 S8_3 S9_3 1000
R87 S8_3 S8_4 1000
R88 S9_3 S10_3 1000
R89 S9_3 S9_4 1000
R90 S10_3 S11_3 1000
R91 S10_3 S10_4 1000
R92 S11_3 S11_4 1000
R93 S0_4 S1_4 1000
R94 S0_4 S0_5 1000
R95 S1_4 S2_4 1000
R96 S1_4 S1_5 1000
R97 S2_4 S3_4 1000
R98 S2_4 S2_5 1000
R99 S3_4 S4_4 1000
R100 S3_4 S3_5 1000
R101 S4_4 S5_4 1000
R102 S4_4 S4_5 1000
R103 S5_4 S6_4 1000
R104 S5_4 S5_5 1000
R105 S6_4 S7_4 1000
R106 S6_4 S6_5 1000
R107 S7_4 S8_4 1000
R108 S7_4 S7_5 1000
R109 S8_4 S9_4 1000
R110 S8_4 S8_5 1000
R111 S9_4 S10_4 1000
R112 S9_4 S9_5 1000
R113 S10_4 S11_4 1000
R114 S10_4 S10_5 1000
R115 S11_4 S11_5 1000
R116 S0_5 S1_5 1000
R117 S0_5 S0_6 1000
R118 S1_5 S2_5 1000
R119 S1_5 S1_6 1000
R120 S2_5 S3_5 1000
R121 S2_5 S2_6 1000
R122 S3_5 S4_5 1000
R123 S3_5 S3_6 1000
R124 S4_5 S5_5 1000
R125 S4_5 S4_6 1000
R126 S5_5 S6_5 1000
R127 S5_5 S5_6 1000
R128 S6_5 S7_5 1000
R129 S6_5 S6_6 1000
R130 S7_5 S8_5 1000
R131 S7_5 S7_6 1000
R132 S8_5 S9_5 1000
R133 S8_5 S8_6 1000
R134 S9_5 S10_5 1000
R135 S9_5 S9_6 1000
R136 S10_5 S11_5 1000
R137 S10_5 S10_6 1000
R138 S11_5 S11_6 1000
R139 S0_6 S1_6 1000
R140 S0_6 S0_7 1000
R141 S1_6 S2_6 1000
R142 S1_6 S1_7 1000
R143 S2_6 S3_6 1000
R144 S2_6 S2_7 1000
R145 S3_6 S4_6 1000
R146 S3_6 S3_7 1000
R147 S4_6 S5_6 1000
R148 S4_6 S4_7 1000
R149 S5_6 S6_6 1000
R150 S5_6 S5_7 1000
R151 S6_6 S7_6 1000
R152 S6_6 S6_7 1000
R153 S7_6 S8_6 1000
R154 S7_6 S7_7 1000
R155 S8_6 S9_6 1000
R156 S8_6 S8_7 1000
R157 S9_6 S10_6 1000
R158 S9_6 S9_7 1000
R159 S10_6 S11_6 1000
R160 S10_6 S10_7 1000
R161 S11_6 S11_7 1000
R162 S0_7 S1_7 1000
R163 S0_7 S0_8 1000
R164 S1_7 S2_7 1000
R165 S1_7 S1_8 1000
R166 S2_7 S3_7 1000
R167 S2_7 S2_8 1000
R168 S3_7 S4_7 1000
R169 S3_7 S3_8 1000
R170 S4_7 S5_7 1000
R171 S4_7 S4_8 1000
R172 S5_7 S6_7 1000
R173 S5_7 S5_8 1000
R174 S6_7 S7_7 1000
R175 S6_7 S6_8 1000
R176 S7_7 S8_7 1000
R177 S7_7 S7_8 1000
R178 S8_7 S9_7 1000
R179 S8_7 S8_8 1000
R180 S9_7 S10_7 1000
R181 S9_7 S9_8 1000
R182 S10_7 S11_7 1000
R183 S10_7 S10_8 1000
R184 S11_7 S11_8 1000
R185 S0_8 S1_8 1000
R186 S0_8 S0_9 1000
R187 S1_8 S2_8 1000
R188 S1_8 S1_9 1000
R189 S2_8 S3_8 1000
R190 S2_8 S2_9 1000
R191 S3_8 S4_8 1000
R192 S3_8 S3_9 1000
R193 S4_8 S5_8 1000
R194 S4_8 S4_9 1000
R195 S5_8 S6_8 1000
R196 S5_8 S5_9 1000
R197 S6_8 S7_8 1000
R198 S6_8 S6_9 1000
R199 S7_8 S8_8 1000
R200 S7_8 S7_9 1000
R201 S8_8 S9_8 1000
R202 S8_8 S8_9 1000
R203 S9_8 S10_8 1000
R204 S9_8 S9_9 1000
R205 S10_8 S11_8 1000
R206 S10_8 S10_9 1000
R207 S11_8 S11_9 1000
R208 S0_9 S1_9 1000
R209 S0_9 S0_10 1000
R210 S1_9 S2_9 1000
R211 S1_9 S1_10 1000
R212 S2_9 S3_9 1000
R213 S2_9 S2_10 1000
R214 S3_9 S4_9 1000
R215 S3_9 S3_10 1000
R216 S4_9 S5_9 1000
R217 S4_9 S4_10 1000
R218 S5_9 S6_9 1000
R219 S5_9 S5_10 1000
R220 S6_9 S7_9 1000
R221 S6_9 S6_10 1000
R222 S7_9 S8_9 1000
R223 S7_9 S7_10 1000
R224 S8_9 S9_9 1000
R225 S8_9 S8_10 1000
R226 S9_9 S10_9 1000
R227 S9_9 S9_10 1000
R228 S10_9 S11_9 1000
R229 S10_9 S10_10 1000
R230 S11_9 S11_10 1000
R231 S0_10 S1_10 1000
R232 S0_10 S0_11 1000
R233 S1_10 S2_10 1000
R234 S1_10 S1_11 1000
R235 S2_10 S3_10 1000
R236 S2_10 S2_11 1000
R237 S3_10 S4_10 1000
R238 S3_10 S3_11 1000
R239 S4_10 S5_10 1000
R240 S4_10 S4_11 1000
R241 S5_10 S6_10 1000
R242 S5_10 S5_11 1000
R243 S6_10 S7_10 1000
R244 S6_10 S6_11 1000
R245 S7_10 S8_10 1000
R246 S7_10 S7_11 1000
R247 S8_10 S9_10 1000
R248 S8_10 S8_11 1000
R249 S9_10 S10_10 1000
R250 S9_10 S9_11 1000
R251 S10_10 S11_10 1000
R252 S10_10 S10_11 1000
R253 S11_10 S11_11 1000
R254 S0_11 S1_11 1000
R255 S1_11 S2_11 1000
R256 S2_11 S3_11 1000
R257 S3_11 S4_11 1000
R258 S4_11 S5_11 1000
R259 S5_11 S6_11 1000
R260 S6_11 S7_11 1000
R261 S7_11 S8_11 1000
R262 S8_11 S9_11 1000
R263 S9_11 S10_11 1000
R264 S10_11 S11_11 1000
R265 S0_0 OUT_A 1000
R266 S11_0 OUT_B 1000
R267 S0_11 OUT_C 1000
R268 S11_11 OUT_D 1000
V_A OUT_A 0 DC 0
V_B OUT_B 0 DC 0
V_C OUT_C 0 DC 0
V_D OUT_D 0 DC 0
.end
