* Anger-DPC-r0.1 on p3.2-g0.2: Dpc, 12 x 12 SiPM nodes
* Gcam TODO-19 charge-division network (RD-10), generated from the engine's readout configuration.
* Illustrative generic network, not a buildable design. I_S<k> = SiPM k (k = ky*Sx + kx), 0 A each;
* a nodal solver drives one source at a time with 1 A. V_<c> = 0 V ammeter (virtual-ground input) or
* R_LOAD_<c> = amplifier input impedance; outputs A..D = x-y-, x+y-, x-y+, x+y+.
I_S0 0 S0_0 DC 0
I_S1 0 S1_0 DC 0
I_S2 0 S2_0 DC 0
I_S3 0 S3_0 DC 0
I_S4 0 S4_0 DC 0
I_S5 0 S5_0 DC 0
I_S6 0 S6_0 DC 0
I_S7 0 S7_0 DC 0
I_S8 0 S8_0 DC 0
I_S9 0 S9_0 DC 0
I_S10 0 S10_0 DC 0
I_S11 0 S11_0 DC 0
I_S12 0 S0_1 DC 0
I_S13 0 S1_1 DC 0
I_S14 0 S2_1 DC 0
I_S15 0 S3_1 DC 0
I_S16 0 S4_1 DC 0
I_S17 0 S5_1 DC 0
I_S18 0 S6_1 DC 0
I_S19 0 S7_1 DC 0
I_S20 0 S8_1 DC 0
I_S21 0 S9_1 DC 0
I_S22 0 S10_1 DC 0
I_S23 0 S11_1 DC 0
I_S24 0 S0_2 DC 0
I_S25 0 S1_2 DC 0
I_S26 0 S2_2 DC 0
I_S27 0 S3_2 DC 0
I_S28 0 S4_2 DC 0
I_S29 0 S5_2 DC 0
I_S30 0 S6_2 DC 0
I_S31 0 S7_2 DC 0
I_S32 0 S8_2 DC 0
I_S33 0 S9_2 DC 0
I_S34 0 S10_2 DC 0
I_S35 0 S11_2 DC 0
I_S36 0 S0_3 DC 0
I_S37 0 S1_3 DC 0
I_S38 0 S2_3 DC 0
I_S39 0 S3_3 DC 0
I_S40 0 S4_3 DC 0
I_S41 0 S5_3 DC 0
I_S42 0 S6_3 DC 0
I_S43 0 S7_3 DC 0
I_S44 0 S8_3 DC 0
I_S45 0 S9_3 DC 0
I_S46 0 S10_3 DC 0
I_S47 0 S11_3 DC 0
I_S48 0 S0_4 DC 0
I_S49 0 S1_4 DC 0
I_S50 0 S2_4 DC 0
I_S51 0 S3_4 DC 0
I_S52 0 S4_4 DC 0
I_S53 0 S5_4 DC 0
I_S54 0 S6_4 DC 0
I_S55 0 S7_4 DC 0
I_S56 0 S8_4 DC 0
I_S57 0 S9_4 DC 0
I_S58 0 S10_4 DC 0
I_S59 0 S11_4 DC 0
I_S60 0 S0_5 DC 0
I_S61 0 S1_5 DC 0
I_S62 0 S2_5 DC 0
I_S63 0 S3_5 DC 0
I_S64 0 S4_5 DC 0
I_S65 0 S5_5 DC 0
I_S66 0 S6_5 DC 0
I_S67 0 S7_5 DC 0
I_S68 0 S8_5 DC 0
I_S69 0 S9_5 DC 0
I_S70 0 S10_5 DC 0
I_S71 0 S11_5 DC 0
I_S72 0 S0_6 DC 0
I_S73 0 S1_6 DC 0
I_S74 0 S2_6 DC 0
I_S75 0 S3_6 DC 0
I_S76 0 S4_6 DC 0
I_S77 0 S5_6 DC 0
I_S78 0 S6_6 DC 0
I_S79 0 S7_6 DC 0
I_S80 0 S8_6 DC 0
I_S81 0 S9_6 DC 0
I_S82 0 S10_6 DC 0
I_S83 0 S11_6 DC 0
I_S84 0 S0_7 DC 0
I_S85 0 S1_7 DC 0
I_S86 0 S2_7 DC 0
I_S87 0 S3_7 DC 0
I_S88 0 S4_7 DC 0
I_S89 0 S5_7 DC 0
I_S90 0 S6_7 DC 0
I_S91 0 S7_7 DC 0
I_S92 0 S8_7 DC 0
I_S93 0 S9_7 DC 0
I_S94 0 S10_7 DC 0
I_S95 0 S11_7 DC 0
I_S96 0 S0_8 DC 0
I_S97 0 S1_8 DC 0
I_S98 0 S2_8 DC 0
I_S99 0 S3_8 DC 0
I_S100 0 S4_8 DC 0
I_S101 0 S5_8 DC 0
I_S102 0 S6_8 DC 0
I_S103 0 S7_8 DC 0
I_S104 0 S8_8 DC 0
I_S105 0 S9_8 DC 0
I_S106 0 S10_8 DC 0
I_S107 0 S11_8 DC 0
I_S108 0 S0_9 DC 0
I_S109 0 S1_9 DC 0
I_S110 0 S2_9 DC 0
I_S111 0 S3_9 DC 0
I_S112 0 S4_9 DC 0
I_S113 0 S5_9 DC 0
I_S114 0 S6_9 DC 0
I_S115 0 S7_9 DC 0
I_S116 0 S8_9 DC 0
I_S117 0 S9_9 DC 0
I_S118 0 S10_9 DC 0
I_S119 0 S11_9 DC 0
I_S120 0 S0_10 DC 0
I_S121 0 S1_10 DC 0
I_S122 0 S2_10 DC 0
I_S123 0 S3_10 DC 0
I_S124 0 S4_10 DC 0
I_S125 0 S5_10 DC 0
I_S126 0 S6_10 DC 0
I_S127 0 S7_10 DC 0
I_S128 0 S8_10 DC 0
I_S129 0 S9_10 DC 0
I_S130 0 S10_10 DC 0
I_S131 0 S11_10 DC 0
I_S132 0 S0_11 DC 0
I_S133 0 S1_11 DC 0
I_S134 0 S2_11 DC 0
I_S135 0 S3_11 DC 0
I_S136 0 S4_11 DC 0
I_S137 0 S5_11 DC 0
I_S138 0 S6_11 DC 0
I_S139 0 S7_11 DC 0
I_S140 0 S8_11 DC 0
I_S141 0 S9_11 DC 0
I_S142 0 S10_11 DC 0
I_S143 0 S11_11 DC 0
R1 L0 S0_0 1000
R2 S0_0 S1_0 1000
R3 S1_0 S2_0 1000
R4 S2_0 S3_0 1000
R5 S3_0 S4_0 1000
R6 S4_0 S5_0 1000
R7 S5_0 S6_0 1000
R8 S6_0 S7_0 1000
R9 S7_0 S8_0 1000
R10 S8_0 S9_0 1000
R11 S9_0 S10_0 1000
R12 S10_0 S11_0 1000
R13 S11_0 R0 1000
R14 L1 S0_1 1000
R15 S0_1 S1_1 1000
R16 S1_1 S2_1 1000
R17 S2_1 S3_1 1000
R18 S3_1 S4_1 1000
R19 S4_1 S5_1 1000
R20 S5_1 S6_1 1000
R21 S6_1 S7_1 1000
R22 S7_1 S8_1 1000
R23 S8_1 S9_1 1000
R24 S9_1 S10_1 1000
R25 S10_1 S11_1 1000
R26 S11_1 R1 1000
R27 L2 S0_2 1000
R28 S0_2 S1_2 1000
R29 S1_2 S2_2 1000
R30 S2_2 S3_2 1000
R31 S3_2 S4_2 1000
R32 S4_2 S5_2 1000
R33 S5_2 S6_2 1000
R34 S6_2 S7_2 1000
R35 S7_2 S8_2 1000
R36 S8_2 S9_2 1000
R37 S9_2 S10_2 1000
R38 S10_2 S11_2 1000
R39 S11_2 R2 1000
R40 L3 S0_3 1000
R41 S0_3 S1_3 1000
R42 S1_3 S2_3 1000
R43 S2_3 S3_3 1000
R44 S3_3 S4_3 1000
R45 S4_3 S5_3 1000
R46 S5_3 S6_3 1000
R47 S6_3 S7_3 1000
R48 S7_3 S8_3 1000
R49 S8_3 S9_3 1000
R50 S9_3 S10_3 1000
R51 S10_3 S11_3 1000
R52 S11_3 R3 1000
R53 L4 S0_4 1000
R54 S0_4 S1_4 1000
R55 S1_4 S2_4 1000
R56 S2_4 S3_4 1000
R57 S3_4 S4_4 1000
R58 S4_4 S5_4 1000
R59 S5_4 S6_4 1000
R60 S6_4 S7_4 1000
R61 S7_4 S8_4 1000
R62 S8_4 S9_4 1000
R63 S9_4 S10_4 1000
R64 S10_4 S11_4 1000
R65 S11_4 R4 1000
R66 L5 S0_5 1000
R67 S0_5 S1_5 1000
R68 S1_5 S2_5 1000
R69 S2_5 S3_5 1000
R70 S3_5 S4_5 1000
R71 S4_5 S5_5 1000
R72 S5_5 S6_5 1000
R73 S6_5 S7_5 1000
R74 S7_5 S8_5 1000
R75 S8_5 S9_5 1000
R76 S9_5 S10_5 1000
R77 S10_5 S11_5 1000
R78 S11_5 R5 1000
R79 L6 S0_6 1000
R80 S0_6 S1_6 1000
R81 S1_6 S2_6 1000
R82 S2_6 S3_6 1000
R83 S3_6 S4_6 1000
R84 S4_6 S5_6 1000
R85 S5_6 S6_6 1000
R86 S6_6 S7_6 1000
R87 S7_6 S8_6 1000
R88 S8_6 S9_6 1000
R89 S9_6 S10_6 1000
R90 S10_6 S11_6 1000
R91 S11_6 R6 1000
R92 L7 S0_7 1000
R93 S0_7 S1_7 1000
R94 S1_7 S2_7 1000
R95 S2_7 S3_7 1000
R96 S3_7 S4_7 1000
R97 S4_7 S5_7 1000
R98 S5_7 S6_7 1000
R99 S6_7 S7_7 1000
R100 S7_7 S8_7 1000
R101 S8_7 S9_7 1000
R102 S9_7 S10_7 1000
R103 S10_7 S11_7 1000
R104 S11_7 R7 1000
R105 L8 S0_8 1000
R106 S0_8 S1_8 1000
R107 S1_8 S2_8 1000
R108 S2_8 S3_8 1000
R109 S3_8 S4_8 1000
R110 S4_8 S5_8 1000
R111 S5_8 S6_8 1000
R112 S6_8 S7_8 1000
R113 S7_8 S8_8 1000
R114 S8_8 S9_8 1000
R115 S9_8 S10_8 1000
R116 S10_8 S11_8 1000
R117 S11_8 R8 1000
R118 L9 S0_9 1000
R119 S0_9 S1_9 1000
R120 S1_9 S2_9 1000
R121 S2_9 S3_9 1000
R122 S3_9 S4_9 1000
R123 S4_9 S5_9 1000
R124 S5_9 S6_9 1000
R125 S6_9 S7_9 1000
R126 S7_9 S8_9 1000
R127 S8_9 S9_9 1000
R128 S9_9 S10_9 1000
R129 S10_9 S11_9 1000
R130 S11_9 R9 1000
R131 L10 S0_10 1000
R132 S0_10 S1_10 1000
R133 S1_10 S2_10 1000
R134 S2_10 S3_10 1000
R135 S3_10 S4_10 1000
R136 S4_10 S5_10 1000
R137 S5_10 S6_10 1000
R138 S6_10 S7_10 1000
R139 S7_10 S8_10 1000
R140 S8_10 S9_10 1000
R141 S9_10 S10_10 1000
R142 S10_10 S11_10 1000
R143 S11_10 R10 1000
R144 L11 S0_11 1000
R145 S0_11 S1_11 1000
R146 S1_11 S2_11 1000
R147 S2_11 S3_11 1000
R148 S3_11 S4_11 1000
R149 S4_11 S5_11 1000
R150 S5_11 S6_11 1000
R151 S6_11 S7_11 1000
R152 S7_11 S8_11 1000
R153 S8_11 S9_11 1000
R154 S9_11 S10_11 1000
R155 S10_11 S11_11 1000
R156 S11_11 R11 1000
R157 OUT_A L0 100
R158 OUT_B R0 100
R159 L0 L1 100
R160 R0 R1 100
R161 L1 L2 100
R162 R1 R2 100
R163 L2 L3 100
R164 R2 R3 100
R165 L3 L4 100
R166 R3 R4 100
R167 L4 L5 100
R168 R4 R5 100
R169 L5 L6 100
R170 R5 R6 100
R171 L6 L7 100
R172 R6 R7 100
R173 L7 L8 100
R174 R7 R8 100
R175 L8 L9 100
R176 R8 R9 100
R177 L9 L10 100
R178 R9 R10 100
R179 L10 L11 100
R180 R10 R11 100
R181 L11 OUT_C 100
R182 R11 OUT_D 100
V_A OUT_A 0 DC 0
V_B OUT_B 0 DC 0
V_C OUT_C 0 DC 0
V_D OUT_D 0 DC 0
.end
